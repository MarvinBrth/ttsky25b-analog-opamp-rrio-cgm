* Private characterization / teaching comparison: schematic
.lib "../../models/selected.lib.spice" tt
.include "../../includes/schematic.inc"
.temp 25
.options klu itl1=500 reltol=0.0001
.nodeset v(out)=1.65
VDD vapwr 0 3.3 AC 0
VDIG vd1v8 0 1.8 AC 0
VIN inp 0 1.65 AC 0
BSERVO inn out V=v(inp)-1.65
IT 0 out DC 0 AC 0
ILOAD out 0 0
CL out 0 20p
XDUT vapwr out inp inn 0 vd1v8 sch_dut

.control
set numdgt=15
set wr_singlescale
set wr_vecnames
set filetype=ascii
save all @m.xdut.xcore.xm1.msky130_fd_pr__nfet_g5v0d10v5[gm] @m.xdut.xcore.xm3.msky130_fd_pr__nfet_g5v0d10v5[gm] @m.xdut.xcore.xm9.msky130_fd_pr__pfet_g5v0d10v5[gm] @m.xdut.xcore.xm10.msky130_fd_pr__pfet_g5v0d10v5[gm]
op
write op.raw all
dc VIN .05 3.25 .05
wrdata gm.dat v(out) i(VDD) @m.xdut.xcore.xm1.msky130_fd_pr__nfet_g5v0d10v5[gm] @m.xdut.xcore.xm3.msky130_fd_pr__nfet_g5v0d10v5[gm] @m.xdut.xcore.xm9.msky130_fd_pr__pfet_g5v0d10v5[gm] @m.xdut.xcore.xm10.msky130_fd_pr__pfet_g5v0d10v5[gm]
write dc.raw all

quit
.endc
.end
