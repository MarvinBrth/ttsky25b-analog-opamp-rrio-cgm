* Private characterization / teaching comparison: schematic
.lib "../../models/selected.lib.spice" tt
.include "../../includes/schematic.inc"
.temp 25
.options klu itl1=500 reltol=0.0001
.nodeset v(out)=1.5675
VDD vapwr 0 3.135 AC 0
VDIG vd1v8 0 1.8 AC 0
VIN inp 0 DC 1.5675 PWL(0 1.5675 1u 1.5675 1.001e-06 1.6175 5e-06 1.6175 5.001e-06 1.5675) AC 0
VJ inn out DC 0 AC 0
IT 0 out DC 0 AC 0
ILOAD out 0 0
CL out 0 20p
XDUT vapwr out inp inn 0 vd1v8 sch_dut

.control
set numdgt=15
set wr_singlescale
set wr_vecnames
set filetype=ascii
op
wrdata op.dat v(out) i(VDD) @m.xdut.xcore.xb.xref.xm1.msky130_fd_pr__pfet_g5v0d10v5[id]
write op.raw all
save v(out) v(inp) i(VDD) @m.xdut.xcore.xb.xref.xm1.msky130_fd_pr__pfet_g5v0d10v5[id]
tran 2e-09 9e-06 0 2e-09
wrdata step.dat v(out) v(inp) i(VDD) @m.xdut.xcore.xb.xref.xm1.msky130_fd_pr__pfet_g5v0d10v5[id]

quit
.endc
.end
