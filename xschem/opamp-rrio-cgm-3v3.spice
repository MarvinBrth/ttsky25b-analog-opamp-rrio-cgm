.subckt opamp_rrio_cgm_3v3 VAPWR diffout IN_P IN_N VGND
*.PININFO in-:I in+:I diffout:O VAPWR:B VGND:B
XM1 net2 IN_N net3 VGND sky130_fd_pr__nfet_g5v0d10v5 L=0.5 W=69.44 nf=5 m=1
XM3 drain IN_P net3 VGND sky130_fd_pr__nfet_g5v0d10v5 L=0.5 W=69.44 nf=5 m=1
XM7 drain bias net3 VGND sky130_fd_pr__nfet_g5v0d10v5 L=0.5 W=69.44 nf=5 m=1
XM8 net2 bias net3 VGND sky130_fd_pr__nfet_g5v0d10v5 L=0.5 W=69.44 nf=5 m=1
XM18 net13 bias3 net5 VGND sky130_fd_pr__nfet_g5v0d10v5 L=0.5 W=13.89 nf=1 m=1
XM19 net12 bias3 net4 VGND sky130_fd_pr__nfet_g5v0d10v5 L=0.5 W=13.89 nf=1 m=1
XM20 net5 net13 VGND VGND sky130_fd_pr__nfet_g5v0d10v5 L=2 W=6.66 nf=2 m=1
XM21 net4 net13 VGND VGND sky130_fd_pr__nfet_g5v0d10v5 L=2 W=6.66 nf=2 m=1
XM22 net3 bias4 VGND VGND sky130_fd_pr__nfet_g5v0d10v5 L=6 W=10 nf=1 m=1
XM25 net8 net8 net11 VGND sky130_fd_pr__nfet_g5v0d10v5 L=0.5 W=13.89 nf=1 m=1
XM26 net10 net8 net12 VGND sky130_fd_pr__nfet_g5v0d10v5 L=0.5 W=13.89 nf=1 m=1
XM30 net11 net11 VGND VGND sky130_fd_pr__nfet_g5v0d10v5 L=2 W=6.66 nf=2 m=1
XM31 net9 bias4 VGND VGND sky130_fd_pr__nfet_g5v0d10v5 L=6 W=10 nf=1 m=1
XM32 diffout net12 VGND VGND sky130_fd_pr__nfet_g5v0d10v5 L=2 W=133.2 nf=40 m=1
XC1 diffout drain sky130_fd_pr__cap_mim_m3_1 W=18 L=18 m=1
XC2 diffout net4 sky130_fd_pr__cap_mim_m3_1 W=30 L=30 m=1
XC2B diffout net4 sky130_fd_pr__cap_mim_m3_1 W=30 L=10 m=1
XM13 net1 bias1 VAPWR VAPWR sky130_fd_pr__pfet_g5v0d10v5 L=6 W=33 nf=1 m=1
XM14 net2 net6 VAPWR VAPWR sky130_fd_pr__pfet_g5v0d10v5 L=2 W=22 nf=2 m=1
XM15 drain net6 VAPWR VAPWR sky130_fd_pr__pfet_g5v0d10v5 L=2 W=22 nf=2 m=1
XM16 net10 bias2 drain VAPWR sky130_fd_pr__pfet_g5v0d10v5 L=0.5 W=45.83 nf=1 m=1
XM23 net8 bias1 VAPWR VAPWR sky130_fd_pr__pfet_g5v0d10v5 L=6 W=33 nf=1 m=1
XM24 net6 bias2 net2 VAPWR sky130_fd_pr__pfet_g5v0d10v5 L=0.5 W=45.83 nf=1 m=1
XM28 net7 net7 VAPWR VAPWR sky130_fd_pr__pfet_g5v0d10v5 L=2 W=22 nf=2 m=1
XM29 diffout net10 VAPWR VAPWR sky130_fd_pr__pfet_g5v0d10v5 L=2 W=440 nf=40 m=1
XM34 net9 net9 net7 VAPWR sky130_fd_pr__pfet_g5v0d10v5 L=0.5 W=45.83 nf=1 m=1
XM35 net12 net9 net10 VAPWR sky130_fd_pr__pfet_g5v0d10v5 L=0.5 W=45.83 nf=1 m=1
XM2 net4 bias net1 VAPWR sky130_fd_pr__pfet_g5v0d10v5 L=0.5 W=229.17 nf=10 m=2
XM4 net5 bias net1 VAPWR sky130_fd_pr__pfet_g5v0d10v5 L=0.5 W=229.17 nf=10 m=2
XM9 net5 IN_N net1 VAPWR sky130_fd_pr__pfet_g5v0d10v5 L=0.5 W=229.17 nf=10 m=2
XM10 net4 IN_P net1 VAPWR sky130_fd_pr__pfet_g5v0d10v5 L=0.5 W=229.17 nf=10 m=2
XB VAPWR VGND bias1 bias4 bias2 bias3 bias opamp_bias_3v3
XMFC_P net13 net9 net6 VAPWR sky130_fd_pr__pfet_g5v0d10v5 L=0.5 W=45.83 nf=1 m=1
XMFC_N net6 net8 net13 VGND sky130_fd_pr__nfet_g5v0d10v5 L=0.5 W=13.89 nf=1 m=1
.ends

* expanding   symbol:  opamp_bias_3v3.sym # of pins=7
** sym_path: /home/ttuser/ttsky25b-analog-opamp-rrio-cgm/xschem/migration_3v3/opamp_bias_3v3.sym
** sch_path: /home/ttuser/ttsky25b-analog-opamp-rrio-cgm/xschem/migration_3v3/opamp_bias_3v3.sch
.subckt opamp_bias_3v3 VAPWR VGND bias1 bias4 bias2 bias3 bias
*.PININFO VAPWR:B VGND:B bias1:O bias4:O bias2:O bias3:O bias:O
XREF VAPWR IREF VGND reference_bias_3v3
XMBN IREF IREF VGND VGND sky130_fd_pr__nfet_g5v0d10v5 L=1 W=5 nf=1 m=1
XMPMASTER PMASTER PMASTER VAPWR VAPWR sky130_fd_pr__pfet_g5v0d10v5 L=1 W=10 nf=1 m=1
XMNMASTER PMASTER IREF VGND VGND sky130_fd_pr__nfet_g5v0d10v5 L=1 W=5 nf=1 m=1
XMPTAIL bias1 bias1 VAPWR VAPWR sky130_fd_pr__pfet_g5v0d10v5 L=6 W=33 nf=1 m=1
XMNPTAIL bias1 IREF VGND VGND sky130_fd_pr__nfet_g5v0d10v5 L=1 W=5 nf=1 m=1
XMPNTAIL bias4 PMASTER VAPWR VAPWR sky130_fd_pr__pfet_g5v0d10v5 L=1 W=10 nf=1 m=1
XMNTAIL bias4 bias4 VGND VGND sky130_fd_pr__nfet_g5v0d10v5 L=6 W=10 nf=1 m=1
XRPCAS PCAS_SOURCE VAPWR VGND sky130_fd_pr__res_high_po_0p69 L=100 mult=1 m=1
XMPCAS bias2 bias2 PCAS_SOURCE VAPWR sky130_fd_pr__pfet_g5v0d10v5 L=0.5 W=45.83 nf=1 m=1
XMNPCAS bias2 IREF VGND VGND sky130_fd_pr__nfet_g5v0d10v5 L=1 W=5 nf=1 m=1
XMPNCAS bias3 PMASTER VAPWR VAPWR sky130_fd_pr__pfet_g5v0d10v5 L=1 W=10 nf=1 m=1
XMNCAS bias3 bias3 NCAS_SOURCE VGND sky130_fd_pr__nfet_g5v0d10v5 L=0.5 W=13.89 nf=1 m=1
XRNCAS VGND NCAS_SOURCE VGND sky130_fd_pr__res_high_po_0p69 L=100 mult=1 m=1
XRCM_TOP bias VAPWR VGND sky130_fd_pr__res_high_po_0p69 L=150 mult=1 m=1
XRCM_BOTTOM VGND bias VGND sky130_fd_pr__res_high_po_0p69 L=150 mult=1 m=1
.ends

* expanding   symbol:  reference_bias_3v3.sym # of pins=3
** sym_path: /home/ttuser/ttsky25b-analog-opamp-rrio-cgm/xschem/migration_3v3/reference_bias_3v3.sym
** sch_path: /home/ttuser/ttsky25b-analog-opamp-rrio-cgm/xschem/migration_3v3/reference_bias_3v3.sch
.subckt reference_bias_3v3 VAPWR IREF VGND
*.PININFO VAPWR:B VGND:B IREF:O
XR1 VGND net1 VGND sky130_fd_pr__res_high_po_0p69 L=30.5 mult=1 m=1
XM40 Vbiasp Vbiasp VAPWR VAPWR sky130_fd_pr__pfet_g5v0d10v5 L=1 W=10 nf=1 m=1
XM44 Vstartup Vbiasn VGND VGND sky130_fd_pr__nfet_g5v0d10v5 L=1 W=3 nf=1 m=1
XM41 Vbiasn Vbiasp VAPWR VAPWR sky130_fd_pr__pfet_g5v0d10v5 L=1 W=10 nf=1 m=1
XM43 Vstartup Vstartup VAPWR VAPWR sky130_fd_pr__pfet_g5v0d10v5 L=10 W=1 nf=1 m=1
XM42 Vbiasn Vbiasn VGND VGND sky130_fd_pr__nfet_g5v0d10v5 L=1 W=5 nf=1 m=1
XM39 Vbiasp Vbiasn net1 VGND sky130_fd_pr__nfet_g5v0d10v5 L=1 W=20 nf=1 m=1
XM45 Vbiasp Vstartup Vbiasn VGND sky130_fd_pr__nfet_g5v0d10v5 L=1 W=2 nf=1 m=1
XM1 IREF Vbiasp VAPWR VAPWR sky130_fd_pr__pfet_g5v0d10v5 L=1 W=10 nf=1 m=1
.ends

.end
